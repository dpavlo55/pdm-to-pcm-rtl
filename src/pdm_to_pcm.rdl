addrmap pdm_to_pcm_reg {
    name = "PDM to PCM converter address map";
    desc = "Little-endian";

    default regwidth = 8;
    default accesswidth = 8;
    default sw = rw;
    default hw = r;
    littleendian;

    reg {
        name = "control";
        desc = "Control register";

        field {
            name = "enable";
            desc = "Enable the PDM to PCM converter";
        } enable [0:0] = 0x0;

    } control;

    reg {
        name = "Register name";
        desc = "Register description";

        regwidth = 16;

        field {
            name = "Field name";
            desc = "Field description";
            sw   = rw;
            hw   = r;
        } high[15:8] = 0x0;

        field {
            name = "Field name";
            desc = "Field description";
            sw   = rw;
            hw   = r;
        } low[7:0] = 0x0;
    } nco_control;

    reg {
        name = "Register name";
        desc = "Register description";

        field {
            name = "Field name";
            desc = "Field description";
            hw = w;
            sw = r;
        } value[7:0] = 0x0;

    } data_right;

    reg {
        name = "Register name";
        desc = "Register description";

        field {
            name = "Field name";
            desc = "Field description";
            hw = w;
            sw = r;
        } value[7:0] = 0x0;

    } data_left;

    reg {
        name = "id";
        desc = "ID register";

        field {
            name = "value";
            desc = "ID field, should read as 0xDA for this device";
            sw = r;
            hw = na;
        } value [7:0] = 8'hDA;

    } id;

};