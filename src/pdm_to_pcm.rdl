addrmap pdm_to_pcm_reg {
    name = "PDM to PCM converter address map";
    desc = "Little-endian";

    default regwidth = 8;
    default accesswidth = 8;
    default sw = rw;
    default hw = r;
    littleendian;

    reg {
        name = "control";
        desc = "Control register";

        field {
            name = "enable";
            desc = "Enable the PDM to PCM converter";
        } enable [0:0] = 0x0;

    } control;

    reg {
        name = "nco_control";
        desc = "NCO step register. Controls the PDM clock frequency.

            The PDM clock frequency is:

            $$f_{PDM} = \\frac{step \\cdot f_{clk}}{2^{17}}$$

            Solving for step:

            $$step = \\frac{f_{PDM} \\cdot 2^{17}}{f_{clk}}$$

            Example: $f_{clk} = 48\\,\\text{MHz}$, $f_{PDM} = 1.536\\,
            \\text{MHz}$ (48 kHz audio, R=32):

            $$step = \\frac{1{,}536{,}000 \\cdot 131072}{48{,}000{,}000} =
            4194$$";

        regwidth = 16;

        field {
            name = "step[15:8]";
            desc = "Upper byte of the 16-bit NCO step value";
            sw   = rw;
            hw   = r;
        } high[15:8] = 0x0;

        field {
            name = "step[7:0]";
            desc = "Lower byte of the 16-bit NCO step value";
            sw   = rw;
            hw   = r;
        } low[7:0] = 0x0;
    } nco_control @ 0x1;

    reg {
        name = "data_right";
        desc = "16-bit signed PCM output for the right audio channel (sampled on
            the falling edge of the PDM clock). Updated by hardware after each CIC
            decimation cycle.

            Read the low byte first: reading the low byte snapshots the high
            byte, so the following high-byte read returns the matching half of
            the same sample even if the CIC updates in between.";

        regwidth = 16;
        buffer_reads = true;

        field {
            name = "pcm[15:8]";
            desc = "Upper byte of the 16-bit PCM sample (buffered on low-byte read).";
            hw = w;
            sw = r;
        } high[15:8] = 0x0;

        field {
            name = "pcm[7:0]";
            desc = "Lower byte of the 16-bit PCM sample.";
            hw = w;
            sw = r;
        } low[7:0] = 0x0;

    } data_right @ 0x3;

    reg {
        name = "data_left";
        desc = "16-bit signed PCM output for the left audio channel (sampled on
            the rising edge of the PDM clock). Updated by hardware after each CIC
            decimation cycle.

            Read the low byte first: reading the low byte snapshots the high
            byte, so the following high-byte read returns the matching half of
            the same sample even if the CIC updates in between.";

        regwidth = 16;
        buffer_reads = true;

        field {
            name = "pcm[15:8]";
            desc = "Upper byte of the 16-bit PCM sample (buffered on low-byte read).";
            hw = w;
            sw = r;
        } high[15:8] = 0x0;

        field {
            name = "pcm[7:0]";
            desc = "Lower byte of the 16-bit PCM sample.";
            hw = w;
            sw = r;
        } low[7:0] = 0x0;

    } data_left @ 0x5;

    reg {
        name = "id";
        desc = "ID register";

        field {
            name = "value";
            desc = "ID field, should read as 0xDA for this device";
            sw = r;
            hw = na;
        } value [7:0] = 8'hDA;

    } id @ 0x7;

};